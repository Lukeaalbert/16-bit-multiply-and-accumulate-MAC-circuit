ADE simulation setup
Run mode: Single Run, Sweeps and Corners
Tests:
  demo_lab1_in_tb_1: demo_lab1/in_tb/schematic, simulator spectre
