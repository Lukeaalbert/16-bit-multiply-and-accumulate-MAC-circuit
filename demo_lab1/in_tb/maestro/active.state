ADE simulation setup
Test demo_lab1_in_tb_1: demo_lab1/in_tb/schematic, simulator spectre
  Models: /home/viterbi/01/ee577/CDS_GPDK45/gpdk045_v_5_0/gpdk045/../models/spectre/gpdk045.scs[mc]
  Temperature: 27
  Stimulus vdd!: voltage dc dc=1
  Stimulus in1: voltage bit rise=10p fall=10p period=1n data=10101
  Analysis tran: stop=10n
  Signals: /in1_wire, /out_wire
Run mode: Single Run, Sweeps and Corners
