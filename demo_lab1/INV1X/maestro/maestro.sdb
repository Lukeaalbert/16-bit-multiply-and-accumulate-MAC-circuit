ADE simulation setup
Run mode: Single Run, Sweeps and Corners
Tests:
  demo_lab1_INV1X_1: demo_lab1/INV1X/schematic, simulator spectre
