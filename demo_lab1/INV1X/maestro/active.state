ADE simulation setup
Test demo_lab1_INV1X_1: demo_lab1/INV1X/schematic, simulator spectre
  Models: /home/viterbi/01/ee577/CDS_GPDK45/gpdk045_v_5_0/gpdk045/../models/spectre/gpdk045.scs[mc]
  Temperature: 27
  Stimulus vdd!: voltage dc dc=1
  Stimulus in: voltage bit rise=10p fall=10p period=1n data=10101010
  Analysis tran: stop=10n
  Signals: /in, /out
Run mode: Single Run, Sweeps and Corners
