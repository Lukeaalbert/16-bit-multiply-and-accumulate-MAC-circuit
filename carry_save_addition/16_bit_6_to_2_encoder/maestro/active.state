ADE simulation setup
Test carry_save_addition_16_bit_6_to_2_encoder_1: carry_save_addition/16_bit_6_to_2_encoder/schematic, simulator spectre
  Models: /home/viterbi/01/ee577/CDS_GPDK45/gpdk045_v_5_0/gpdk045/../models/spectre/gpdk045.scs[mc]
  Temperature: 27
  Files: vectors /home/viterbi/08/vemurina/work_gpdk045/16-bit-multiply-and-accumulate-MAC-circuit/project_phase_2.vec
  Stimulus vdd!: voltage dc dc=1
  Analysis tran: stop=10n
  Signals: /out0_7, /out0_8, /out0_9, /out0_10, /out0_11, /out0_12, /out0_13, /out0_14, /out0_15, /out1_0, /out1_1, /out1_2, /out1_3, /out1_4, /out1_5, /out1_6, /out1_7, /out1_8, /out1_9, /out1_15, /out1_10, /out1_11, /out1_12, /out1_13, /out1_14, /out0_0, /out0_1, /out0_2, /out0_3, /out0_4, /out0_5, /out0_6
Run mode: Single Run, Sweeps and Corners
