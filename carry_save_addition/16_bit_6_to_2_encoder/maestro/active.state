ADE simulation setup
Test carry_save_addition_16_bit_6_to_2_encoder_1: carry_save_addition/16_bit_6_to_2_encoder/schematic, simulator spectre
  Models: /home/viterbi/01/ee577/CDS_GPDK45/gpdk045_v_5_0/gpdk045/../models/spectre/gpdk045.scs[mc]
  Temperature: 27
  Files: vectors /home/viterbi/08/vemurina/work_gpdk045/16-bit-multiply-and-accumulate-MAC-circuit/project_phase_2.vec
  Stimulus vdd!: voltage dc dc=1
  Analysis tran: stop=10n
  Signals: /net12, /net295, /net293, /net309, /net289, /net290, /net291, /net292, /net308, /net307, /net306, /net305, /net304, /net303
Run mode: Single Run, Sweeps and Corners
