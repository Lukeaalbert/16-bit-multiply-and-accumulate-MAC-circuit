ADE simulation setup
Test carry_save_addition_16_bit_3_to_2_encoder_1: carry_save_addition/16_bit_3_to_2_encoder/schematic, simulator spectre
  Models: /home/viterbi/01/ee577/CDS_GPDK45/gpdk045_v_5_0/gpdk045/../models/spectre/gpdk045.scs[mc]
  Temperature: 27
  Stimulus a0: voltage bit rise=10p fall=10p period=1n data=01
  Stimulus a1: voltage bit rise=10p fall=10p period=1n data=01
  Stimulus a2: voltage bit rise=10p fall=10p period=1n data=10
  Stimulus a3: voltage bit rise=10p fall=10p period=1n data=00
  Stimulus b0: voltage bit rise=10p fall=10p period=1n data=11
  Stimulus b1: voltage bit rise=10p fall=10p period=1n data=00
  Stimulus b2: voltage bit rise=10p fall=10p period=1n data=01
  Stimulus b3: voltage bit rise=10p fall=10p period=1n data=01
  Stimulus c0: voltage bit rise=10p fall=10p period=1n data=11
  Stimulus c1: voltage bit rise=10p fall=10p period=1n data=00
  Stimulus c2: voltage bit rise=10p fall=10p period=1n data=01
  Stimulus c3: voltage bit rise=10p fall=10p period=1n data=11
  Stimulus c15: voltage bit rise=10p fall=10p period=1n data=11
  Stimulus c14: voltage bit rise=10p fall=10p period=1n data=10
  Stimulus c13: voltage bit rise=10p fall=10p period=1n data=00
  Stimulus c12: voltage bit rise=10p fall=10p period=1n data=11
  Stimulus b15: voltage bit rise=10p fall=10p period=1n data=00
  Stimulus b14: voltage bit rise=10p fall=10p period=1n data=11
  Stimulus b13: voltage bit rise=10p fall=10p period=1n data=01
  Stimulus b12: voltage bit rise=10p fall=10p period=1n data=11
  Stimulus a15: voltage bit rise=10p fall=10p period=1n data=00
  Stimulus b6: voltage bit rise=10p fall=10p period=1n data=00
  Stimulus a4: voltage bit rise=10p fall=10p period=1n data=00
  Stimulus a14: voltage bit rise=10p fall=10p period=1n data=01
  Stimulus a13: voltage bit rise=10p fall=10p period=1n data=10
  Stimulus a12: voltage bit rise=10p fall=10p period=1n data=11
  Stimulus c5: voltage bit rise=10p fall=10p period=1n data=00
  Stimulus a7: voltage bit rise=10p fall=10p period=1n data=00
  Stimulus c11: voltage bit rise=10p fall=10p period=1n data=01
  Stimulus c10: voltage bit rise=10p fall=10p period=1n data=10
  Stimulus c9: voltage bit rise=10p fall=10p period=1n data=10
  Stimulus c8: voltage bit rise=10p fall=10p period=1n data=01
  Stimulus b11: voltage bit rise=10p fall=10p period=1n data=11
  Stimulus b7: voltage bit rise=10p fall=10p period=1n data=10
  Stimulus a5: voltage bit rise=10p fall=10p period=1n data=11
  Stimulus b10: voltage bit rise=10p fall=10p period=1n data=10
  Stimulus b9: voltage bit rise=10p fall=10p period=1n data=11
  Stimulus b8: voltage bit rise=10p fall=10p period=1n data=01
  Stimulus a11: voltage bit rise=10p fall=10p period=1n data=00
  Stimulus a10: voltage bit rise=10p fall=10p period=1n data=11
  Stimulus a9: voltage bit rise=10p fall=10p period=1n data=01
  Stimulus c6: voltage bit rise=10p fall=10p period=1n data=00
  Stimulus b4: voltage bit rise=10p fall=10p period=1n data=00
  Stimulus a8: voltage bit rise=10p fall=10p period=1n data=10
  Stimulus c7: voltage bit rise=10p fall=10p period=1n data=01
  Stimulus c4: voltage bit rise=10p fall=10p period=1n data=00
  Stimulus a6: voltage bit rise=10p fall=10p period=1n data=01
  Stimulus b5: voltage bit rise=10p fall=10p period=1n data=00
  Stimulus vdd!: voltage dc dc=1
  Analysis tran: stop=10n
  Signals: /out1_0, /out1_1, /out1_2, /out1_3, /out1_4, /out0_0, /out0_1, /out0_2, /out0_3, /out1_5, /out1_6, /out1_7, /out1_8, /out0_4, /out0_5, /out0_6, /out0_7, /out1_9, /out1_10, /out1_11, /out1_12, /out0_8, /out0_11, /out0_10, /out0_9, /out1_13, /out1_14, /out1_15, /net13, /out0_12, /out0_13, /out0_14, /out0_15
Run mode: Single Run, Sweeps and Corners
