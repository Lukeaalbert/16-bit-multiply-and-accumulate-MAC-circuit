ADE simulation setup
Run mode: Single Run, Sweeps and Corners
Tests:
  carry_save_addition_16_bit_3_to_2_encoder_1: carry_save_addition/16_bit_3_to_2_encoder/schematic, simulator spectre
