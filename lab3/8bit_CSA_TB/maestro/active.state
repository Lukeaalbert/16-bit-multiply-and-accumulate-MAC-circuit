ADE simulation setup
Test lab3_8bit_CSA_TB_1: lab3/8bit_CSA_TB/schematic, simulator spectre
  Models: /home/viterbi/01/ee577/CDS_GPDK45/gpdk045_v_5_0/gpdk045/../models/spectre/gpdk045.scs[mc]
  Temperature: 27
  Stimulus a0: voltage bit rise=10p fall=10p period=1n data=1111
  Stimulus a1: voltage bit rise=10p fall=10p period=1n data=1111
  Stimulus a2: voltage bit rise=10p fall=10p period=1n data=1111
  Stimulus a3: voltage bit rise=10p fall=10p period=1n data=1111
  Stimulus a4: voltage bit rise=10p fall=10p period=1n data=1111
  Stimulus a5: voltage bit rise=10p fall=10p period=1n data=1111
  Stimulus a6: voltage bit rise=10p fall=10p period=1n data=1100
  Stimulus a7: voltage bit rise=10p fall=10p period=1n data=1111
  Stimulus b0: voltage bit rise=10p fall=10p period=1n data=0111
  Stimulus b1: voltage bit rise=10p fall=10p period=1n data=0000
  Stimulus b2: voltage bit rise=10p fall=10p period=1n data=0000
  Stimulus b3: voltage bit rise=10p fall=10p period=1n data=0001
  Stimulus b4: voltage bit rise=10p fall=10p period=1n data=0000
  Stimulus b5: voltage bit rise=10p fall=10p period=1n data=0000
  Stimulus cin: voltage bit rise=10p fall=10p period=1n data=0000
  Stimulus b7: voltage bit rise=10p fall=10p period=1n data=0000
  Stimulus b6: voltage bit rise=10p fall=10p period=1n data=0000
  Stimulus vdd!: voltage dc dc=1
  Analysis tran: stop=10n
  Signals: /a0, /a1, /a2, /a3, /a4, /a5, /a6, /a7, /b0, /b1, /b2, /b3, /b4, /b5, /b6, /b7, /cin, /cout, /s0, /s1, /s2, /s3, /s4, /s6, /s5, /s7
Run mode: Single Run, Sweeps and Corners
