ADE simulation setup
Run mode: Single Run, Sweeps and Corners
Tests:
  lab3_8bit_CSA_TB_1: lab3/8bit_CSA_TB/schematic, simulator spectre
