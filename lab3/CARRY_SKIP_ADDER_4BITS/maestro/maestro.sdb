ADE simulation setup
Run mode: Single Run, Sweeps and Corners
Tests:
  lab3_CARRY_SKIP_ADDER_4BITS_1: lab3/CARRY_SKIP_ADDER_4BITS/schematic, simulator spectre
