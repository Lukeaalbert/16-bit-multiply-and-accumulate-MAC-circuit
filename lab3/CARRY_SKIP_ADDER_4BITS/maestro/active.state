ADE simulation setup
Test lab3_CARRY_SKIP_ADDER_4BITS_1: lab3/CARRY_SKIP_ADDER_4BITS/schematic, simulator spectre
  Models: /home/viterbi/01/ee577/CDS_GPDK45/gpdk045_v_5_0/gpdk045/../models/spectre/gpdk045.scs[mc]
  Temperature: 27
  Stimulus a0: voltage bit rise=10p fall=10p period=1n data=111 rpttimes=111
  Stimulus a1: voltage bit rise=10p fall=10p period=1n data=111 rpttimes=111
  Stimulus a2: voltage bit rise=10p fall=10p period=1n data=111 rpttimes=111
  Stimulus a3: voltage bit rise=10p fall=10p period=1n data=111 rpttimes=111
  Stimulus b0: voltage bit rise=10p fall=10p period=1n data=010
  Stimulus b1: voltage bit rise=10p fall=10p period=1n data=000
  Stimulus b2: voltage bit rise=10p fall=10p period=1n data=000
  Stimulus b3: voltage bit rise=10p fall=10p period=1n data=000
  Stimulus cin: voltage bit rise=10p fall=10p period=1n data=000
  Stimulus vdd!: voltage dc dc=1
  Analysis tran: stop=10n
  Signals: /a0, /a1, /a2, /a3, /b0, /b1, /b2, /b3, /cin, /propagate, /cout, /propagate_cout, /s0, /s1, /s2, /s3
Run mode: Single Run, Sweeps and Corners
