ADE simulation setup
Test lab3_CARRY_SKIP_ADDER_8BITS_1: lab3/CARRY_SKIP_ADDER_8BITS/schematic, simulator spectre
  Models: /home/viterbi/01/ee577/CDS_GPDK45/gpdk045_v_5_0/gpdk045/../models/spectre/gpdk045.scs[mc]
  Temperature: 27
  Stimulus a0: voltage bit rise=10p fall=10p period=1n data=11111
  Stimulus a1: voltage bit rise=10p fall=10p period=1n data=11111
  Stimulus a2: voltage bit rise=10p fall=10p period=1n data=11111
  Stimulus a3: voltage bit rise=10p fall=10p period=1n data=11111
  Stimulus b0: voltage bit rise=10p fall=10p period=1n data=01111
  Stimulus b1: voltage bit rise=10p fall=10p period=1n data=00000
  Stimulus b2: voltage bit rise=10p fall=10p period=1n data=00000
  Stimulus b3: voltage bit rise=10p fall=10p period=1n data=00011
  Stimulus cin: voltage bit rise=10p fall=10p period=1n data=00001
  Stimulus a4: voltage bit rise=10p fall=10p period=1n data=11111
  Stimulus a5: voltage bit rise=10p fall=10p period=1n data=11111
  Stimulus a6: voltage bit rise=10p fall=10p period=1n data=11000
  Stimulus a7: voltage bit rise=10p fall=10p period=1n data=11111
  Stimulus b4: voltage bit rise=10p fall=10p period=1n data=00000
  Stimulus b5: voltage bit rise=10p fall=10p period=1n data=00000
  Stimulus b6: voltage bit rise=10p fall=10p period=1n data=00000
  Stimulus b7: voltage bit rise=10p fall=10p period=1n data=00000
  Stimulus vdd!: voltage dc dc=1
  Analysis tran: stop=10n
  Signals: /cin, /b3, /b2, /b1, /b0, /a3, /a2, /a1, /a0, /b7, /b6, /b5, /b4, /a7, /a6, /a5, /a4, /s3, /s2, /s1, /s0, /s7, /s6, /s5, /s4, /cout
Run mode: Single Run, Sweeps and Corners
