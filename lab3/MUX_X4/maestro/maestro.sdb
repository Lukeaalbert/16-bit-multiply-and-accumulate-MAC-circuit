ADE simulation setup
Run mode: Single Run, Sweeps and Corners
Tests:
  lab3_MUX_1X_1: lab3/MUX_X1/schematic, simulator spectre
