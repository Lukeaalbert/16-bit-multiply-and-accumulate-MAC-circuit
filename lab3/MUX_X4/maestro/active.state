ADE simulation setup
Test lab3_MUX_1X_1: lab3/MUX_X1/schematic, simulator spectre
  Models: /home/viterbi/01/ee577/CDS_GPDK45/gpdk045_v_5_0/gpdk045/../models/spectre/gpdk045.scs[mc]
  Temperature: 27
  Stimulus vdd!: voltage dc dc=1
  Stimulus a: voltage bit rise=10p fall=10p period=1n data=0011110
  Stimulus b: voltage bit rise=10p fall=10p period=1n data=1110000
  Stimulus s: voltage bit rise=10p fall=10p period=1n data=0111000
  Analysis tran: stop=10n
  Signals: /a, /b, /s, /out
Run mode: Single Run, Sweeps and Corners
