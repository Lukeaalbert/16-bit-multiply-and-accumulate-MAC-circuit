ADE simulation setup
Test final_project_16bitadder_tb_1: final_project/16bitadder_tb/schematic, simulator spectre
  Models: /home/viterbi/01/ee577/CDS_GPDK45/gpdk045_v_5_0/gpdk045/../models/spectre/gpdk045.scs[mc]
  Temperature: 27
  Files: vectors /home/viterbi/08/vemurina/work_gpdk045/csa_16bit.vec
  Stimulus vdd!: voltage dc dc=1
  Analysis tran: stop=10n errpreset=conservative
  Signals: /a0_in, /a1_in, /a2_in, /a3_in, /a4_in, /a5_in, /a6_in, /a7_in, /a8_in, /a9_in, /a10_in, /a11_in, /a12_in, /a13_in, /a14_in, /a15_in, /b0_in, /b1_in, /b2_in, /b3_in, /b4_in, /b5_in, /b6_in, /b7_in, /b8_in, /b9_in, /b10_in, /b11_in, /b12_in, /b13_in, /b14_in, /b15_in, /cin_in, /s0_out, /s1_out, /s2_out, /s3_out, /s4_out, /s5_out, /s6_out, /s7_out, /s8_out, /s9_out, /s10_out, /s11_out, /s12_out, /s13_out, /s14_out, /s15_out, /cout
Run mode: Single Run, Sweeps and Corners
