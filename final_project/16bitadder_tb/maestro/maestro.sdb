ADE simulation setup
Run mode: Single Run, Sweeps and Corners
Tests:
  final_project_16bitadder_tb_1: final_project/16bitadder_tb/schematic, simulator spectre
