ADE simulation setup
Test final_project_booth_encoder_1: final_project/booth_encoder/schematic, simulator spectre
  Models: /home/viterbi/01/ee577/CDS_GPDK45/gpdk045_v_5_0/gpdk045/../models/spectre/gpdk045.scs[mc]
  Temperature: 27
  Files: vectors /home/viterbi/08/vemurina/work_gpdk045/booth_encoder.vec
  Stimulus vdd!: voltage dc dc=1
  Analysis tran: stop=10n errpreset=conservative
  Signals: /x0, /x1, /Y7, /Y6, /Y5, /Y4, /Y3, /Y2, /Y1, /Y0, /PP8, /PP7, /PP6, /PP5, /PP4, /PP3, /PP2, /PP1, /PP0, /Single, /Double, /x2
