ADE simulation setup
Run mode: Single Run, Sweeps and Corners
Tests:
  lab2_XOR_tb_1: lab2/XOR_tb/schematic, simulator spectre
