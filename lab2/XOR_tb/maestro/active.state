ADE simulation setup
Test lab2_XOR_tb_1: lab2/XOR_tb/schematic, simulator spectre
  Models: /home/viterbi/01/ee577/CDS_GPDK45/gpdk045_v_5_0/gpdk045/../models/spectre/gpdk045.scs[mc]
  Temperature: 27
  Stimulus A: voltage bit rise=10p fall=10p period=1n data=0110
  Stimulus B: voltage bit rise=10p fall=10p period=1n data=0011
  Stimulus vdd!: voltage dc dc=1
  Analysis tran: stop=10n
  Signals: /ain, /bin, /output_final
Run mode: Single Run, Sweeps and Corners
