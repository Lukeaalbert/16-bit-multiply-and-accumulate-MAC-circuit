ADE simulation setup
Run mode: Single Run, Sweeps and Corners
Tests:
  lab2_1bit_addr_1: lab2/1bit_addr/schematic, simulator spectre
