ADE simulation setup
Run mode: Single Run, Sweeps and Corners
Tests:
  lab2_1bit_addr_p2_1: lab2/1bit_addr_p2/schematic, simulator spectre
