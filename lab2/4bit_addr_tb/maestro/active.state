ADE simulation setup
Test lab2_4bit_addr_tb_1: lab2/4bit_addr_tb/schematic, simulator spectre
  Models: /home/viterbi/01/ee577/CDS_GPDK45/gpdk045_v_5_0/gpdk045/../models/spectre/gpdk045.scs[mc]
  Temperature: 27
  Stimulus vdd!: voltage dc dc=1
  Stimulus a0: voltage bit rise=10ps fall=10ps period=1ns data=111111
  Stimulus a1: voltage bit rise=10ps fall=10ps period=1ns data=111111
  Stimulus a2: voltage bit rise=10ps fall=10ps period=1ns data=111111
  Stimulus a3: voltage bit rise=10ps fall=10ps period=1ns data=111111
  Stimulus b0: voltage bit rise=10ps fall=10ps period=1ns data=000000
  Stimulus b1: voltage bit rise=10ps fall=10ps period=1ns data=000000
  Stimulus b2: voltage bit rise=10ps fall=10ps period=1ns data=000000
  Stimulus b3: voltage bit rise=10ps fall=10ps period=1ns data=000000
  Stimulus c0: voltage bit rise=10ps fall=10ps period=1ns data=010101
  Analysis tran: stop=10n
  Signals: /c0, /s3, /c4, /s2, /s1, /s0, /a2, /a1, /a0, /a3
