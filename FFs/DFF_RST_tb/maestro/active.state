ADE simulation setup
Test FFs_DFF_RST_tb_1: FFs/DFF_RST_tb/schematic, simulator spectre
  Models: /home/viterbi/01/ee577/CDS_GPDK45/gpdk045_v_5_0/gpdk045/../models/spectre/gpdk045.scs[mc]
  Temperature: 27
  Stimulus vdd!: voltage dc dc=1
  Stimulus D: voltage bit rise=10p fall=10p period=1n data=0011001111110011
  Stimulus clk: voltage bit rise=10p fall=10p period=1n data=0101010101010101
  Stimulus rst: voltage bit rise=10p fall=10p period=1n data=1100110011110000
  Analysis tran: stop=20n
  Signals: /rst_in, /D_in, /clk_in, /Q_out
Run mode: Single Run, Sweeps and Corners
