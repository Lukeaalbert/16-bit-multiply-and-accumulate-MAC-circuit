ADE simulation setup
Run mode: Single Run, Sweeps and Corners
Tests:
  FFs_DFF_RST_tb_1: FFs/DFF_RST_tb/schematic, simulator spectre
