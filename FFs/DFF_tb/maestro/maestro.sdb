ADE simulation setup
Run mode: Single Run, Sweeps and Corners
Tests:
  FFs_DFF_tb_1: FFs/DFF_tb/schematic, simulator spectre
