ADE simulation setup
Test FFs_DFF_tb_1: FFs/DFF_tb/schematic, simulator spectre
  Models: /home/viterbi/01/ee577/CDS_GPDK45/gpdk045_v_5_0/gpdk045/../models/spectre/gpdk045.scs[mc]
  Temperature: 27
  Stimulus D: voltage bit rise=10p fall=10p period=500.0p data=0111100011000011
  Stimulus clk: voltage bit rise=10p fall=10p period=1n data=01010101
  Stimulus vdd!: voltage dc dc=1
  Analysis tran: stop=10n
  Signals: /D, /clk, /D_in, /clk_in, /Q_out
Run mode: Single Run, Sweeps and Corners
