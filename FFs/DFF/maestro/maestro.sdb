ADE simulation setup
Run mode: Single Run, Sweeps and Corners
Tests:
  FFs_DFF_1: FFs/DFF/schematic, simulator spectre
