ADE simulation setup
Test FFs_DFF_1: FFs/DFF/schematic, simulator spectre
  Models: /home/viterbi/01/ee577/CDS_GPDK45/gpdk045_v_5_0/gpdk045/../models/spectre/gpdk045.scs[mc]
  Temperature: 27
  Stimulus vdd!: voltage dc dc=1
  Stimulus D: voltage bit rise=10p fall=10p period=500.0p data=1001111100101101
  Stimulus clk: voltage bit rise=10p fall=10p period=1n data=10101010
  Analysis tran: stop=10n
  Signals: /D, /clk, /Q
Run mode: Single Run, Sweeps and Corners
