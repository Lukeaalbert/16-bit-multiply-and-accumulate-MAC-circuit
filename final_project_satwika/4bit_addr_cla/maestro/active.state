ADE simulation setup
Test final_project_4bit_addr_cla_1: final_project/4bit_addr_cla/schematic, simulator spectre
  Models: /home/viterbi/01/ee577/CDS_GPDK45/gpdk045_v_5_0/gpdk045/../models/spectre/gpdk045.scs[mc]
  Temperature: 27
  Files: vectors /home/viterbi/08/vemurina/work_gpdk045/csa_4bit.vec
  Stimulus vdd!: voltage dc dc=1
  Analysis tran: stop=10n errpreset=conservative
  Signals: /S0, /S1, /S2, /S3, /a0, /a1, /a2, /a3, /b0, /b1, /b2, /b3, /Cout, /cin
Run mode: Single Run, Sweeps and Corners
