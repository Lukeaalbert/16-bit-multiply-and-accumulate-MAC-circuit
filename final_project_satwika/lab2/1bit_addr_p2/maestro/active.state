ADE simulation setup
Test lab2_1bit_addr_p2_1: lab2/1bit_addr_p2/schematic, simulator spectre
  Models: /home/viterbi/01/ee577/CDS_GPDK45/gpdk045_v_5_0/gpdk045/../models/spectre/gpdk045.scs[mc]
  Temperature: 27
  Stimulus A: voltage bit rise=10ps fall=10ps period=1ns data=11110000
  Stimulus B: voltage bit rise=10ps fall=10ps period=1ns data=11001100
  Stimulus Cin: voltage bit rise=10ps fall=10ps period=1ns data=10011001
  Stimulus vdd!: voltage dc dc=1
  Analysis tran: stop=10n
  Signals: /A, /B, /Cin, /S, /Cout
