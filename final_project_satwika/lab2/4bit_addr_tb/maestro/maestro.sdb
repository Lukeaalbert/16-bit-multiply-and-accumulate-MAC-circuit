ADE simulation setup
Run mode: Single Run, Sweeps and Corners
Tests:
  lab2_4bit_addr_tb_1: lab2/4bit_addr_tb/schematic, simulator spectre
