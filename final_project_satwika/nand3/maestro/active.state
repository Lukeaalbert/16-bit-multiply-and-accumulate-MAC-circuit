ADE simulation setup
Test final_project_nand3_1: final_project/nand3/schematic, simulator spectre
  Models: /home/viterbi/01/ee577/CDS_GPDK45/gpdk045_v_5_0/gpdk045/../models/spectre/gpdk045.scs[mc]
  Temperature: 27
  Stimulus vdd!: voltage dc dc=1
  Stimulus A: voltage bit rise=10p fall=10p period=1n data=00001111
  Stimulus B: voltage bit rise=10p fall=10p period=1n data=00111100
  Stimulus C: voltage bit rise=10p fall=10p period=1n data=01100110
  Analysis tran: stop=10n errpreset=conservative
  Signals: /A, /B, /C, /out, /NM0/S (terminal), /NM0/G (terminal), /NM0/B (terminal), /NM0/D (terminal)
Run mode: Single Run, Sweeps and Corners
