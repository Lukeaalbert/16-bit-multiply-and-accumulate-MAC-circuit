ADE simulation setup
Run mode: Single Run, Sweeps and Corners
Tests:
  final_project_nand3_1: final_project/nand3/schematic, simulator spectre
