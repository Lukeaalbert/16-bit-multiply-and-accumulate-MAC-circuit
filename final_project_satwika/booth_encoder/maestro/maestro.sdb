ADE simulation setup
Run mode: Single Run, Sweeps and Corners
Tests:
  final_project_booth_encoder_1: final_project/booth_encoder/schematic, simulator spectre
