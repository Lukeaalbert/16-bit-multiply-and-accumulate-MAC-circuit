ADE simulation setup
Test final_project_16bit_addr_cla_1: final_project/16bit_addr_cla/schematic, simulator spectre
  Models: /home/viterbi/01/ee577/CDS_GPDK45/gpdk045_v_5_0/gpdk045/../models/spectre/gpdk045.scs[mc]
  Temperature: 27
  Files: vectors /home/viterbi/08/vemurina/work_gpdk045/csa_16bit.vec
  Stimulus vdd!: voltage dc dc=1
  Analysis tran: stop=10n errpreset=conservative
  Signals: /A15, /A14, /A13, /A12, /A11, /A10, /A9, /A8, /A7, /A6, /A5, /A4, /A3, /A2, /A1, /A0, /B15, /B14, /B13, /B12, /B11, /B10, /B9, /B8, /B7, /B6, /B5, /B4, /B3, /B2, /B1, /B0, /Cin, /S15, /S14, /S13, /S12, /S11, /S10, /S9, /S8, /S7, /S6, /S5, /S4, /S3, /S2, /S1, /S0, /Cout
Run mode: Single Run, Sweeps and Corners
