ADE simulation setup
Run mode: Single Run, Sweeps and Corners
Tests:
  final_project_16bit_addr_cla_1: final_project/16bit_addr_cla/schematic, simulator spectre
    Outputs: /B11
