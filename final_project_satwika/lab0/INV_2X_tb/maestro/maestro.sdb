ADE simulation setup
Run mode: Single Run, Sweeps and Corners
Tests:
  lab0_INV2X_tb_1: lab0/INV_2X_tb/config, simulator spectre
