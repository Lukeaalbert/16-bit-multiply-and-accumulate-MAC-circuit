ADE simulation setup
Test lab0_NAND2_2X_tb_1: lab0/NAND2_2X_tb/config, simulator spectre
  Models: /home/viterbi/01/ee577/CDS_GPDK45/gpdk045_v_5_0/gpdk045/../models/spectre/gpdk045.scs[mc]
  Temperature: 27
  Stimulus vdd!: voltage dc dc=1
  Stimulus B: voltage bit val1=1 val0=0 rise=10ps fall=10ps period=1n data=01100110
  Stimulus A: voltage bit val1=1 val0=0 rise=10ps fall=10ps period=1n data=00110011
  Analysis tran: stop=10n
  Signals: /ain, /bin, /output_final
Run mode: Single Run, Sweeps and Corners
