ADE simulation setup
Run mode: Single Run, Sweeps and Corners
Tests:
  lab2__4bit_fa_tb_1: lab2_/4bit_fa_tb/schematic, simulator spectre
