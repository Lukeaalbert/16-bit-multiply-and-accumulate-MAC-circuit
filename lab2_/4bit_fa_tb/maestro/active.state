ADE simulation setup
Test lab2__4bit_fa_tb_1: lab2_/4bit_fa_tb/schematic, simulator spectre
  Models: /home/viterbi/01/ee577/CDS_GPDK45/gpdk045_v_5_0/gpdk045/../models/spectre/gpdk045.scs[mc]
  Temperature: 27
  Stimulus vdd!: voltage dc dc=1
  Stimulus a0: voltage bit rise=10p fall=10p period=1n data=00
  Stimulus a1: voltage bit rise=10p fall=10p period=1n data=00
  Stimulus a2: voltage bit rise=10p fall=10p period=1n data=00
  Stimulus a3: voltage bit rise=10p fall=10p period=1n data=00
  Stimulus b0: voltage bit rise=10p fall=10p period=1n data=101
  Stimulus b1: voltage bit rise=10p fall=10p period=1n data=11
  Stimulus b2: voltage bit rise=10p fall=10p period=1n data=11
  Stimulus b3: voltage bit rise=10p fall=10p period=1n data=11
  Stimulus cin: voltage bit rise=10p fall=10p period=1n data=1
  Analysis tran: stop=10n
  Signals: /a0_inv, /a1_inv, /a2_inv, /a3_inv, /b0_inv, /b1_inv, /b2_inv, /b3_inv, /cin_inv, /cout_raw, /s0_raw, /s1_raw, /s2_raw, /s3_raw
Run mode: Single Run, Sweeps and Corners
