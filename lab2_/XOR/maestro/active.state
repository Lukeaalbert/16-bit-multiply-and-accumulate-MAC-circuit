ADE simulation setup
Test lab2_XOR_1: lab2/XOR/schematic, simulator spectre
  Models: /home/viterbi/01/ee577/CDS_GPDK45/gpdk045_v_5_0/gpdk045/../models/spectre/gpdk045.scs[mc]
  Temperature: 27
  Stimulus a: voltage bit rise=10p fall=10p period=1n data=10111
  Stimulus b: voltage bit rise=10p fall=10p period=1n data=11101
  Stimulus vdd!: voltage dc dc=1
  Analysis tran: stop=10n
  Signals: /a, /b, /out
