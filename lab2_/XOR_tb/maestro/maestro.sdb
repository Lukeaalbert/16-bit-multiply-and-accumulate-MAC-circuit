ADE simulation setup
Run mode: Single Run, Sweeps and Corners
Tests:
  lab2__XOR_tb_1: lab2_/XOR_tb/schematic, simulator spectre
