ADE simulation setup
Test lab2__XOR_tb_1: lab2_/XOR_tb/schematic, simulator spectre
  Models: /home/viterbi/01/ee577/CDS_GPDK45/gpdk045_v_5_0/gpdk045/../models/spectre/gpdk045.scs[mc]
  Temperature: 27
  Stimulus vdd!: voltage dc dc=1
  Stimulus a: voltage bit rise=10p fall=10p period=1n data=00011
  Stimulus b: voltage bit rise=10p fall=10p period=1n data=01001
  Analysis tran: stop=10n
  Signals: /a_inv, /b_inv, /out_raw
Run mode: Single Run, Sweeps and Corners
