ADE simulation setup
Run mode: Single Run, Sweeps and Corners
Tests:
  lab2__tb_fa_1: lab2_/tb_fa/schematic, simulator spectre
