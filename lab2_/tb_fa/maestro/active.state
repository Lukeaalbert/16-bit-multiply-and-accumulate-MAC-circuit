ADE simulation setup
Test lab2__tb_fa_1: lab2_/tb_fa/schematic, simulator spectre
  Models: /home/viterbi/01/ee577/CDS_GPDK45/gpdk045_v_5_0/gpdk045/../models/spectre/gpdk045.scs[mc]
  Temperature: 27
  Stimulus vdd!: voltage dc dc=1
  Stimulus a: voltage bit rise=10p fall=10p period=1n data=1101
  Stimulus b: voltage bit rise=10p fall=10p period=1n data=1000
  Stimulus cin: voltage bit rise=10p fall=10p period=1n data=1111
  Analysis tran: stop=10n
  Signals: /a_inv, /b_inv, /cin_inv, /cout_raw, /sum_raw
Run mode: Single Run, Sweeps and Corners
