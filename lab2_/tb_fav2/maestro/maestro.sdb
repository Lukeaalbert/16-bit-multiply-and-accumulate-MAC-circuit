ADE simulation setup
Run mode: Single Run, Sweeps and Corners
Tests:
  lab2__tb_fav2_1: lab2_/tb_fav2/schematic, simulator spectre
