ADE simulation setup
Run mode: Single Run, Sweeps and Corners
Tests:
  lab0_NAND2X_1: lab0/NAND2_1X/schematic, simulator spectre
