ADE simulation setup
Test lab0_NAND2X_1: lab0/NAND2_1X/schematic, simulator spectre
  Models: /home/viterbi/01/ee577/CDS_GPDK45/gpdk045_v_5_0/gpdk045/../models/spectre/gpdk045.scs[mc]
  Temperature: 27
  Stimulus vdd!: voltage dc dc=1
  Stimulus A: voltage bit val1=1 val0=0 rise=10p fall=10p period=1n data=01100110
  Stimulus B: voltage bit val1=1 val0=0 rise=10p fall=10p period=1n data=00110011
  Analysis tran: stop=10n
  Signals: /B, /A, /out
Run mode: Single Run, Sweeps and Corners
