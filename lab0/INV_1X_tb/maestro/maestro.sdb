ADE simulation setup
Run mode: Single Run, Sweeps and Corners
Tests:
  lab0_INV_tb_1: lab0/INV_1X_tb/config, simulator spectre
