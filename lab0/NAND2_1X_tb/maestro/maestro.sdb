ADE simulation setup
Run mode: Single Run, Sweeps and Corners
Tests:
  lab0_NAND2_1X_tb_1: lab0/NAND2_1X_tb/config, simulator spectre
