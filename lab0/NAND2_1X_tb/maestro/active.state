ADE simulation setup
Test lab0_NAND2_1X_tb_1: lab0/NAND2_1X_tb/config, simulator spectre
  Models: /home/viterbi/01/ee577/CDS_GPDK45/gpdk045_v_5_0/gpdk045/../models/spectre/gpdk045.scs[mc]
  Temperature: 27
  Stimulus vdd!: voltage dc dc=1
  Stimulus A: voltage bit rise=10p fall=10p period=1n data=00110011
  Stimulus B: voltage bit rise=10p fall=10p period=1n data=01100110
  Analysis tran: stop=10n
  Signals: /output_final, /ain, /bin
Run mode: Single Run, Sweeps and Corners
