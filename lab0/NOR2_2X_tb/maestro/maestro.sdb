ADE simulation setup
Run mode: Single Run, Sweeps and Corners
Tests:
  lab0_NOR2_2X_tb_1: lab0/NOR2_2X_tb/config, simulator spectre
