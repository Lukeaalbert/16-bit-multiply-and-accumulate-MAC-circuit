ADE simulation setup
Test lab0_INV2X_tb_1: lab0/INV_2X_tb/config, simulator spectre
  Models: /home/viterbi/01/ee577/CDS_GPDK45/gpdk045_v_5_0/gpdk045/../models/spectre/gpdk045.scs[mc]
  Temperature: 27
  Stimulus vdd!: voltage dc dc=1
  Stimulus A: voltage bit val1=0 val0=1 rise=10ps fall=10ps period=1ns data=01010101
  Analysis tran: stop=10n
  Signals: /in, /out_final
