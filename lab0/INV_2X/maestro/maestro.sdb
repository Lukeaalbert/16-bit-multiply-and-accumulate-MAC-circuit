ADE simulation setup
Run mode: Single Run, Sweeps and Corners
Tests:
  lab0_INV2X_1: lab0/INV_2X/schematic, simulator spectre
